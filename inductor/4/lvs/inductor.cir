* Auto schematic for XFMR_SQ_4P (transformer)
.SUBCKT XFMR_SQ_4P P1 P2 S1 S2
Rpri P1 P2 0.01
Rsec S1 S2 0.01
.ENDS
