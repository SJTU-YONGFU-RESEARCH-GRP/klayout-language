* Reference schematic for lvs/ (KLayout SPICE reader)
* Device L=0.18um W=0.50um — matches generate_layout.rb
* Subcircuit names = layout cell names
* Pin B = substrate / bulk (connect_global SUBSTRATE + PTIE tap)

.SUBCKT NMOS_GOOD S G D B
M1 D G S B NMOS L=0.18U W=0.50U
.ENDS

.SUBCKT NMOS_BAD S G D B
M1 D G S B NMOS L=0.18U W=0.50U
.ENDS
