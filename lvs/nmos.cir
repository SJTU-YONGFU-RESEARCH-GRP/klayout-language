* Reference schematic for the NMOS LVS demo (KLayout SPICE)
* Device: L=0.18um  W=0.50um  — matches generate_layout.rb
*
* Subcircuit names match layout cell names (NMOS_GOOD / NMOS_BAD).

* Pin B is the substrate / bulk terminal (global SUBSTRATE in extraction).

.SUBCKT NMOS_GOOD S G D B
M1 D G S B NMOS L=0.18U W=0.50U
.ENDS

.SUBCKT NMOS_BAD S G D B
M1 D G S B NMOS L=0.18U W=0.50U
.ENDS
